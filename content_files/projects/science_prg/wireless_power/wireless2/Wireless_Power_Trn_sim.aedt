# Ansys Electronics Desktop project, version 2022.1
materials:
  vacuum: permittivity=1
  copper: permeability=0.999991 conductivity=58000000
  aluminum: permeability=1.000021 conductivity=38000000
  titanium: permeability=1.00018 conductivity=1820000
  epoxy_Kevlar_xy: permittivity=3.6
  FDK6H41: permeability=2400 magnetic_loss_tangent=0.0024

design two_coil_sim (Maxwell 3D, EddyCurrent, model units mm)
variables:
  input_height = 3mm  # height of the input coil
  output_height = 3mm  # height of the output coil
  output_radius_small = 25mm
  input_radius_small = 25mm
  disp_z_in = 0+in_disp_z
  disp_z_out = -(output_height+out_disp_z)
  in_disp_z = 25mm
  out_disp_z = 1mm
  input_radius_add = input_radius_big-input_radius_small
  output_radius_add = output_radius_big-output_radius_small
  box_x_middle_in = -0.5*box_x_in
  box_y_middle_in = -0.5*box_y_in meter
  box_x_in = 200mm
  box_y_in = 200mm
  box_z_in = 2mm
  box_x_out = 200mm
  box_y_out = 200mm
  box_z_out = 2mm
  box_x_middle_out = -0.5*box_x_out
  box_y_middle_out = -0.5*box_y_out
  region_center_x = -0.5*region_x_len
  region_center_y = -0.5*region_y_len
  region_center_z = -0.5*region_z_len
  region_x_len = 7.5*box_x_in
  region_y_len = 7.5*box_x_in
  region_z_len = 7.5*box_x_in
  core_input_r_small = 10mm
  core_input_r_add = (core_input_r_big-core_input_r_small) mm
  core_input_height = 1mm
  core_output_r_small = 10mm
  core_output_r_add = (core_output_r_big-core_output_r_small) mm
  core_output_height = 1mm
  core_input_z_disp = input_height + disp_z_in
  core_output_z_disp = disp_z_out-core_output_height
  shield_out_disp_z = core_output_z_disp-box_z_out
  shield_in_disp_z = core_input_z_disp+core_input_height
  shield_out_disp_y = slide
  slide = 0.3mm
  coil_out_disp_y = slide
  core_out_disp_y = slide
  input_current = 10000mA
  input_wind_num = 20
  output_current = 0mA
  output_wind_num = 20
  input_current_freq = 10MHz
  input_radius_big = 60mm
  output_radius_big = 60mm
  rotate_angle_x = 0deg
  rotate_angle_y = 0deg
  core_input_r_big = 70mm
  core_output_r_big = 70mm
geometry:
  coordinate_system RelativeCS1 = origin=(0mm, 0mm, -0.45mm) x=(1mm, 0mm, 0mm) y=(0mm, 1mm, 0mm)
  input_coil [copper] = rectangle(corner=(0mm, input_radius_small, 0mm), y_size=input_radius_add, z_size=input_height)
  input_coil.sweep_around_axis(axis=Z, angle=360deg)
  input_coil.move(0mm, 0mm, disp_z_in)
  current_input_face = input_coil.section(plane=ZX)
  current_input_face.split(plane=YZ, keep=Both) in RelativeCS1
  output_coil [copper] = rectangle(corner=(0mm, output_radius_small, 0), y_size=output_radius_add, z_size=output_height)
  output_coil.sweep_around_axis(axis=Z, angle=360deg)
  output_coil.move(0mm, coil_out_disp_y, disp_z_out)
  coordinate_system RelativeCS2 = origin=(0mm, 0mm, -0.45mm) x=(1mm, 0mm, 0mm) y=(0mm, 1mm, 0mm) in RelativeCS1
  current_output_face [copper] = output_coil.section(plane=ZX) in RelativeCS1
  current_output_face.split(plane=YZ, keep=Both) in RelativeCS1
  shield_input [aluminum] = box(corner=(box_x_middle_in, box_y_middle_in, 0), size=(box_x_in, box_y_in, box_z_in))
  shield_output [aluminum] = box(corner=(box_x_middle_out, box_y_middle_out, 0), size=(box_x_out, box_y_out, box_z_out))
  region [vacuum] = box(corner=(region_center_x, region_center_y, region_center_z), size=(region_x_len, region_y_len, region_z_len))
  core_input [FDK6H41] = rectangle(corner=(0mm, core_input_r_small, 0mm), y_size=core_input_r_big, z_size=core_input_height)
  core_input.sweep_around_axis(axis=Z, angle=360deg)
  core_output [FDK6H41] = rectangle(corner=(0mm, core_output_r_small, 0mm), y_size=core_output_r_big, z_size=core_output_height)
  core_output.sweep_around_axis(axis=Z, angle=360deg)
  core_input.move(0mm, 0mm, core_input_z_disp)
  core_output.move(0mm, core_out_disp_y, core_output_z_disp)
  shield_input.move(0mm, 0mm, shield_in_disp_z)
  shield_output.move(0mm, shield_out_disp_y, shield_out_disp_z)
  [shield_output, output_coil, core_output].rotate(axis=X, angle=rotate_angle_x)
  [shield_output, output_coil, core_output].rotate(axis=Y, angle=rotate_angle_y)
boundaries and excitations:
  input_coil_terminal: Coil Terminal Objects=current_input_face Conductor_number=20 Winding=input_winding Point_out_of_terminal=false
  output_coil_terminal: Coil Terminal Objects=current_output_face Conductor_number=20 Winding=output_winding Point_out_of_terminal=false
  input_winding: Winding Group Type=Current IsSolid=false Current=input_current ParallelBranchesNum=input_wind_num Phase=0deg
  output_winding: Winding Group Type=Current IsSolid=false Current=output_current ParallelBranchesNum=output_wind_num Phase=0deg
parameters:
  Matrix1: Matrix input_winding, output_winding:
mesh:
  core_mesh_input: LengthBased RefineInside Objects=core_input MaxLength=32mm
  core_mesh_output: LengthBased RefineInside Objects=core_output MaxLength=32mm
  input_coil_mesh: LengthBased RefineInside Objects=input_coil MaxLength=20mm
  output_coil_mesh: LengthBased RefineInside Objects=output_coil MaxLength=20mm
  initial mesh: GlobalCurvilinear{Apply}
setups:
  Setup1: EddyCurrent MaximumPasses=10 MinimumPasses=2 MinimumConvergedPasses=1 PercentRefinement=30 PercentError=1 NonLinearResidual=0.001 Frequency=input_current_freq
optimetrics:
  ParametricSetup1: Parametric Sim._Setups=[Setup1]
    sweep out_disp_z: 10mm
field plots:
  Mesh1: MeshPlots in core_input, input_coil, output_coil, core_output, shield_input, shield_output on Setup1 : LastAdaptive at Freq=10MHz Phase=0deg
reports:
  Coupling Coeff Table 1: Matrix1.CplCoef(output_winding,input_winding) vs Freq on Setup1 : LastAdaptive [input_height=all output_height=all output_radius_small=all input_radius_small=all in_disp_z=all out_disp_z=all]
